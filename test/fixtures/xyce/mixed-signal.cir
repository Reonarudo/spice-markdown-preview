* Mixed-signal front end, in the shape of a Xyce deck (RG ch.2)
.PREPROCESS REPLACEGROUND TRUE
.GLOBAL_PARAM vdd=1.8
.PARAM wn=1u wp={wn * 2}
.GLOBAL $GVDD
.OPTIONS DEVICE TEMP=25
   lines that start with a blank are comments in Xyce, even this one
	R99 a b 1k
VDD $GVDD 0 {vdd}
VIN in gnd PULSE(0 {vdd} 0 0.1n 0.1n 5n 10n)
RIN in gnd rmod 1k ; model before the value
.MODEL rmod R (TC1=0.01)
.SUBCKT INV IN OUT PARAMS: W=1u
MP OUT IN $GVDD $GVDD pch L=0.18u W={W * 2}
MN OUT IN GND! GND! nch L=0.18u W={W}
.SUBCKT LOAD A
CL A ground 10f
.ENDS LOAD
XL OUT LOAD
.ENDS INV
X1 in out1 INV PARAMS: W=2u
X2 out1 out2 INV
M3 out2 out1 ground mvs L=100n W=1u
Q1 $GVDD out2 vout [SUB] qpnp 2
U1 AND(2) $GVDD gnd out1 out2 y dmod
UINV NOT $GVDD gnd y yb dmod
S1 vout 0 swi OFF CONTROL={V(y) - 0.5}
P1 yb 0 port=1 Z0=50
.MODEL nch NMOS LEVEL=9
.MODEL pch PMOS LEVEL=9
.MODEL mvs NMOS LEVEL=2000
.MODEL qpnp PNP
.MODEL dmod DIG (CLO=1e-12 CHI=1e-12)
.MODEL swi SWITCH (RON=1 ROFF=1MEG)
.TRAN 1n 100n
.PRINT TRAN V(out2) V(y)
.END
R9 a 0 1k
